// Copyright lowRISC contributors.
// Licensed under the Apache License, Version 2.0, see LICENSE for details.
// SPDX-License-Identifier: Apache-2.0
{
  name: "scmi",
  clock_primary: "clk_i",
  bus_interfaces: [
        { protocol: "reg_iface", direction: "device"}
    ],
  regwidth: "64",
  registers: [
    { name: "reserved",
      hwext: "true",
      hwqe:  "true",
      desc: "Reserved, must be 0",
      swaccess: "rw",
      hwaccess: "none",
      fields: [
        { bits: "31:0" }
      ],
    },
    { name: "channel_status",
      desc: "Indicates which entity has access to the Shared Memory",
      swaccess: "rw",
      hwaccess: "hro",
      fields: [
        { bits: "1",
          name: "channel_error",
          desc: "Must be 0 in absence of errors"
        },
        { bits: "0",
          name: "channel_free",
          desc: "If 1 the agent own the channel, if 0 the platform own the channel"
        }
      ],
    },
    { name: "reserved_impl_defined",
      desc: "Reserved, implementation defined",
      swaccess: "rw",
      hwaccess: "none",
      fields: [
        { bits: "31:0" }
      ],
    },
    { name: "channel_flags",
      desc: "Defines wheter interrupts or polling is used for communication",
      swaccess: "rw",
      hwaccess: "none",
      fields: [
        { bits: "1",
          name: "Reserved",
          desc: "Must be 0"
        },
        { bits: "0",
          name: "intr_enable",
          desc: "If 1 interruts are used, if 0 polling is used"
        }
      ],
    },
    { name: "length",
      desc: "Defines wheter interrupts or polling is used for communication",
      swaccess: "rw",
      hwaccess: "none",
      fields: [
        { bits: "31:0" }
      ],
    },
    { name: "message_header",
      desc: "Defines which commanad the message contain",
      swaccess: "rw",
      hwaccess: "none",
      fields: [
        { bits: "27:18",
          name: "Token",
          desc: "must be same for the msg responses associated to a msg whith the same header"
        },
        { bits: "17:10",
          name: "Protocol_id",
          desc: "Identifies to which protocol the command belongs to"
        },
        { bits: "9:8",
          name: "Message_type",
          desc: "can be 0,1,2,3 depending on the kind of msg to be sent"
        },
        { bits: "7:0",
          name: "Message_id",
          desc: "unique identifier for each command availabe in the protocol pointed by protocol_id"
        }
      ],
    },
    { name: "message_payload",
      desc: "memory region dedicated to the parameters of the commands and their returns",
      swaccess: "rw",
      hwaccess: "none",
      fields: [
        { bits: "31:0" }
      ],
    },
  ],
}
